* stella graph resistor network (1 ohm per edge) — rung 8.3
R1 1 0 1
R2 1 2 1
R3 1 3 1
R4 1 5 1
R5 1 6 1
R6 1 7 1
R7 1 9 1
R8 1 11 1
R9 1 14 1
R10 1 15 1
R11 1 17 1
R12 1 18 1
R13 1 19 1
R14 1 21 1
R15 0 2 1
R16 0 3 1
R17 0 4 1
R18 0 7 1
R19 0 8 1
R20 0 9 1
R21 0 10 1
R22 0 16 1
R23 0 17 1
R24 0 19 1
R25 0 20 1
R26 0 22 1
R27 0 26 1
R28 2 4 1
R29 2 5 1
R30 2 6 1
R31 2 8 1
R32 2 10 1
R33 2 11 1
R34 2 17 1
R35 2 18 1
R36 2 20 1
R37 2 21 1
R38 2 22 1
R39 2 23 1
R40 3 4 1
R41 3 5 1
R42 3 6 1
R43 3 8 1
R44 3 9 1
R45 3 10 1
R46 3 12 1
R47 3 14 1
R48 3 19 1
R49 3 21 1
R50 3 22 1
R51 3 24 1
R52 4 5 1
R53 4 6 1
R54 4 7 1
R55 4 10 1
R56 4 12 1
R57 4 13 1
R58 4 22 1
R59 4 23 1
R60 4 24 1
R61 4 25 1
R62 4 26 1
R63 5 7 1
R64 5 8 1
R65 5 10 1
R66 5 11 1
R67 5 13 1
R68 5 14 1
R69 5 16 1
R70 5 21 1
R71 5 23 1
R72 5 26 1
R73 6 7 1
R74 6 8 1
R75 6 12 1
R76 6 15 1
R77 6 17 1
R78 6 18 1
R79 6 19 1
R80 6 20 1
R81 6 24 1
R82 6 25 1
R83 7 8 1
R84 7 9 1
R85 7 12 1
R86 7 13 1
R87 7 15 1
R88 7 16 1
R89 7 19 1
R90 7 25 1
R91 7 26 1
R92 8 12 1
R93 8 14 1
R94 8 16 1
R95 8 17 1
R96 8 20 1
R97 8 21 1
R98 8 24 1
R99 8 26 1
R100 9 10 1
R101 9 11 1
R102 9 12 1
R103 9 14 1
R104 9 15 1
R105 9 16 1
R106 9 18 1
R107 9 20 1
R108 9 24 1
R109 9 25 1
R110 10 11 1
R111 10 12 1
R112 10 13 1
R113 10 16 1
R114 10 17 1
R115 10 18 1
R116 10 19 1
R117 10 25 1
R118 11 13 1
R119 11 14 1
R120 11 15 1
R121 11 17 1
R122 11 19 1
R123 11 20 1
R124 11 22 1
R125 11 25 1
R126 11 26 1
R127 12 13 1
R128 12 14 1
R129 12 15 1
R130 12 17 1
R131 12 18 1
R132 12 21 1
R133 12 23 1
R134 13 14 1
R135 13 15 1
R136 13 16 1
R137 13 18 1
R138 13 19 1
R139 13 21 1
R140 13 22 1
R141 13 24 1
R142 14 16 1
R143 14 17 1
R144 14 18 1
R145 14 20 1
R146 14 22 1
R147 14 23 1
R148 15 16 1
R149 15 17 1
R150 15 20 1
R151 15 21 1
R152 15 23 1
R153 15 24 1
R154 15 26 1
R155 16 17 1
R156 16 22 1
R157 16 23 1
R158 16 24 1
R159 16 25 1
R160 17 23 1
R161 17 25 1
R162 17 26 1
R163 18 19 1
R164 18 20 1
R165 18 21 1
R166 18 23 1
R167 18 24 1
R168 18 25 1
R169 19 20 1
R170 19 21 1
R171 19 22 1
R172 19 25 1
R173 19 26 1
R174 20 22 1
R175 20 23 1
R176 20 24 1
R177 20 26 1
R178 21 22 1
R179 21 23 1
R180 21 24 1
R181 21 26 1
R182 22 23 1
R183 22 24 1
R184 22 25 1
R185 23 25 1
R186 23 26 1
R187 24 25 1
R188 24 26 1
R189 25 26 1
V1 1 0 1
.op
.end
